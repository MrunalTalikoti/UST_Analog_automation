* ============================================================
* GENERATED BY INVERSE DESIGN OPTIMIZER v3
* ============================================================
* Target Specifications:
*   Gain = 20.000000
*   PM   = 85.000000
*   UGF  = 15.000000
*
* Optimized Parameters:
*   a = 5.595589e-06 m (Width of differential input pair)
*   b = 1.826254e-04 m (Width of PMOS active load)
*   c = 2.423131e-06 m (Width of NMOS current mirror)
*   d = 4.451153e-05 m (Width of PMOS output stage)
*
* Predicted Performance:
*   Gain = 20.149641 (Error: 0.7482%)
*   PM   = 87.448540 (Error: 2.8806%)
*   UGF  = 13.716216 (Error: 8.5586%)
*
* Maximum Error: 8.5586%
* Total Loss: 3.881965
* ============================================================
*
************************************************************************
* auCdl Netlist:
*
* Library Name:  2stageopamp
* Top Cell Name: opamptwostage
* View Name:     schematic
* Netlisted on:  Feb 12 12:40:18 2026
************************************************************************

*.BIPOLAR
*.RESI = 2000
*.RESVAL
*.CAPVAL
*.DIOPERI
*.DIOAREA
*.EQUATION
*.SCALE METER
*.MEGA
.PARAM

************************************************************************
* Library Name: 2stageopamp
* Cell Name:    opamptwostage
* View Name:    schematic
************************************************************************

.SUBCKT opamptwostage GND VDD V_inn V_inp V_out
*.PININFO V_inn:I V_inp:I V_out:O GND:B VDD:B
MPM3 V_out net2 VDD VDD pmos W=4.451153e-05 L=180n M=1
MPM2 net2 net1 VDD VDD pmos W=1.826254e-04 L=180n M=1
MPM1 net1 net1 VDD VDD pmos W=1.826254e-04 L=180n M=1
MPM4 net6 net6 VDD VDD pmos W=610n L=180n M=1
MNM4 net4 net6 GND GND nmos W=2.423131e-06 L=180n M=1
MNM3 V_out net6 GND GND nmos W=2.423131e-06 L=180n M=1
MNM2 net2 V_inp net4 GND nmos W=5.595589e-06 L=180n M=1
MNM1 net1 V_inn net4 GND nmos W=5.595589e-06 L=180n M=1
MNM0 net6 net6 GND GND nmos W=2.423131e-06 L=180n M=1
MM0 V_out net5 V_out V_out pmoscap W=13.695u L=13.695u M=1
RR0 net2 net5 5K $[polyhres] $W=600n $L=8.465u
.ENDS
